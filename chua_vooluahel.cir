* Chua vooluahela ngspice sisendfail

R1 N003 N001 22K
R2 N002 N001 220
R3 N003 N006 22K
R4 N001 N007 1.55k
R5 0 N006 3.3K
R6 0 N005 2.2K
R7 N005 N002 220

C2 N007 0 100n
C1 N001 0 10n

V1 N008 0 dc -9
V2 N004 0 dc 9

L1 N007 N009 10m
L2 N009 0 10m

XU1 N001 N005 N004 N008 N002 LM324
XU2 N001 N006 N004 N008 N003 LM324
.include LM324.sub.txt

.options savecurrents

.control
tran 1us 50ms
.endc

.end
